ADE simulation setup
Run mode: Single Run, Sweeps and Corners
Tests:
  CSRO:csro:1: CSRO/csro/schematic, simulator spectre
Global variables:
  Vctrl = {Inclusion List}0.5{Inclusion List}{From/To}Linear:0.5:0.1:1.0{From/To}

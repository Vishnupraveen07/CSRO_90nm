ADE simulation setup
Test CSRO_csro_1: CSRO/csro/schematic, simulator spectre
  Models: /home/install/FOUNDRY/analog/90nm/libs.oa22/gpdk090/../../models/spectre/gpdk090.scs[NN]
  Temperature: 27
  Analysis tran: stop=100n errpreset=moderate
Run mode: Single Run, Sweeps and Corners

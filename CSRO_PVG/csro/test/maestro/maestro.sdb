ADE simulation setup
Run mode: Single Run, Sweeps and Corners
Tests:
  CSRO_csro_1: CSRO/csro/schematic, simulator spectre

ADE simulation setup
Test CSRO_csro_tb_1: CSRO/csro_tb/schematic, simulator spectre
  Models: /home/install/FOUNDRY/analog/90nm/libs.oa22/gpdk090/../../models/spectre/gpdk090.scs[NN]
  Temperature: 27
  Analysis tran: stop=100n errpreset=moderate
  Output average(getData(":pwr" ?result "tran"))
  Output frequency(VT("/Vosc"))
  Signals: /net1, /vout

ADE simulation setup
Test CSRO_csro_tb_1: CSRO/csro_tb/schematic, simulator spectre
  Models: /home/install/FOUNDRY/analog/90nm/libs.oa22/gpdk090/../../models/spectre/gpdk090.scs[NN]
  Variables: Vctrl = 1
  Temperature: 27
  Analysis tran: stop=100n errpreset=moderate
  Signals: /Vosc

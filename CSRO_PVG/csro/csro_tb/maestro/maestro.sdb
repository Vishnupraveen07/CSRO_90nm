ADE simulation setup
Run mode: Single Run, Sweeps and Corners
Tests:
  CSRO_csro_tb_1: CSRO/csro_tb/schematic, simulator spectre
    Variables: Vctrl = 1

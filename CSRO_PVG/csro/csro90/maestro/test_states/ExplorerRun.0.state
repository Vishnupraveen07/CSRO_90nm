ADE simulation setup
Test CSRO_csro_1: CSRO/csro/schematic, simulator spectre
  Models: /home/install/FOUNDRY/analog/90nm/libs.oa22/gpdk090/../../models/spectre/gpdk090.scs[NN]
  Variables: Vctrl = 1; Vosc = 1.8
  Temperature: 27
  Initial conditions: /Vosc = 0.1
  Analysis tran: stop=100n errpreset=moderate
  Output frequency = frequency(VT("/Vosc"))
  Output avg_power = average(getData(":pwr" ?result "tran"))
  Signals: /Vosc as Vout

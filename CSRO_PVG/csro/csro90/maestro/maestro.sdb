ADE simulation setup
Run mode: Single Run, Sweeps and Corners
Tests:
  CSRO_csro_1: CSRO/csro/schematic, simulator spectre
    Variables: Vctrl = {Inclusion List}1{Inclusion List}{From/To}Auto:0,1:11:1{From/To}; Vosc = 1.8

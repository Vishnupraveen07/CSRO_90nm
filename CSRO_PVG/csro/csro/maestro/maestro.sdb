ADE simulation setup
Run mode: Single Run, Sweeps and Corners
Tests:
  CSRO_csro_1: CSRO/csro/schematic, simulator spectre
    Variables: Vctrl = 1
Global variables:
  Vctrl = {Inclusion List}1{Inclusion List}{From/To}Auto:1:5:0.5{From/To}
Corners (all switched off):
  model folders: /home/install/FOUNDRY/analog/90nm/libs.oa22/gpdk090/../../models/spectre
  C0: temperature=-40; gpdk090.scs[FF]
  C1: temperature=27; gpdk090.scs[FF]
  C2: temperature=125; gpdk090.scs[FF]
  C3: temperature=-40; gpdk090.scs[FS]
  C4: temperature=27; gpdk090.scs[FS]
  C5: temperature=125; gpdk090.scs[FS]
  C6: temperature=-40; gpdk090.scs[NN]
  C7: temperature=27; gpdk090.scs[NN]
  C8: temperature=125; gpdk090.scs[NN]
  C9: temperature=-40; gpdk090.scs[SF]
  C10: temperature=27; gpdk090.scs[SF]
  C11: temperature=125; gpdk090.scs[SF]
  C12: temperature=-40; gpdk090.scs[SS]
  C13: temperature=27; gpdk090.scs[SS]
  C14: temperature=125; gpdk090.scs[SS]
